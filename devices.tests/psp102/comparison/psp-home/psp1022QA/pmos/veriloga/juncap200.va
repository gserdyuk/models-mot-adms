//======================================================================================
//======================================================================================
// Filename: juncap200.va
//======================================================================================
//======================================================================================
//
//  (c) Copyright 2007, All Rights Reserved, NXP Semiconductors
//
//
//  Version: 200.3, October 2007
//
//======================================================================================
//======================================================================================
//
// Further information can be found in the file readme.txt
//

`include "discipline.h"

`include "SIMKIT_macrodefs.include"

`include "JUNCAP200_macrodefs.include"

/////////////////////////////////////////////////////////////////////////////
//
//  Start of JUNCAP2 model code
//
/////////////////////////////////////////////////////////////////////////////

module JUNCAP200(A,K)
    `P(
      info="JUNCAP2 Model"
      simkit:name="juncap200"
      simkit:desc="jc_2"
    );

//
//  Node definitions
//
inout A,K;
electrical A,K;

    ///////////////////////////////
    //  JUNCAP2 model parameters
    ///////////////////////////////

    parameter real LEVEL      = 200                               `P(info="Model level must be 200" unit="");
    parameter real TYPE       = 1      `from(-1.0         , 1.0 ) `P(info="Type parameter, in output value 1 reflects n-type, -1 reflects p-type" unit="");
    parameter real TRJ        = 21     `from(`TRJ_cliplow , inf ) `P(info="Reference temperature" unit="C");
    parameter real DTA        = 0                                 `P(info="Temperature offset with respect to ambient temperature" unit="C");
    `include "JUNCAP200_parlist.include"

    //  Instance parameters
    parameter real AB         = 1E-12  `from(`AB_cliplow  , inf ) `P(type="instance" info="Junction area" unit="m^2" );
    parameter real LS         = 1E-6   `from(`LS_cliplow  , inf ) `P(type="instance" info="STI-edge part of junction perimeter" unit="m" );
    parameter real LG         = 1E-6   `from(`LG_cliplow  , inf ) `P(type="instance" info="Gate-edge part of junction perimeter" unit="m" );
    parameter real MULT       = 1      `from(`MULT_cliplow, inf ) `P(type="instance" info="Number of devices in parallel" unit="" );

    //////////////////////////
    //
    //  Variables
    //
    //////////////////////////

    real MULT_i;
    real EPSSI;

    `define JUNCAP_StandAlone
    `include "JUNCAP200_varlist1.include"
    `include "JUNCAP200_varlist2.include"

`ifdef insideADMS // OPinfo

    /////////////////////////////////////////////////////////////////////////////
    //
    // Variables for operating point info
    //
    /////////////////////////////////////////////////////////////////////////////

    real vak       `P(ask="yes" info="Voltage between anode and cathode" unit="V");
    real cj        `P(ask="yes" info="Total source junction capacitance" unit="F");
    real cjbot     `P(ask="yes" info="Junction capacitance (bottom component)" unit="F");
    real cjgat     `P(ask="yes" info="Junction capacitance (gate-edge component)" unit="F");
    real cjsti     `P(ask="yes" info="Junction capacitance (STI-edge component)" unit="F");
    real ij        `P(ask="yes" info="Total source junction current" unit="A");
    real ijbot     `P(ask="yes" info="Junction current (bottom component)" unit="A");
    real ijgat     `P(ask="yes" info="Junction current (gate-edge component)" unit="A");
    real ijsti     `P(ask="yes" info="Junction current (STI-edge component)" unit="A");
    real si        `P(ask="yes" info="Total junction current noise spectral density" unit="A^2/Hz");

`endif // insideADMS OPinfo

    /////////////////////////////////////////////////////////////////////////////
    //
    //  Analog block with all calculations and contribs
    //
    /////////////////////////////////////////////////////////////////////////////

    analog begin

        begin : initializeModel

            EPSSI      =  `EPSO * `EPSRSI;
            `include "JUNCAP200_InitModel.include"

        end // initializeModel

        // Code independent of bias but dependent on instance parameters
        begin : initializeInstance

            // Clipping of the local model parameters
            AB_i   = `CLIP_LOW(AB  , `AB_cliplow);
            LS_i   = `CLIP_LOW(LS  , `LS_cliplow);
            LG_i   = `CLIP_LOW(LG  , `LG_cliplow);
            MULT_i = `CLIP_LOW(MULT, `MULT_cliplow);

            exp_VMAX_over_phitd = 0.0;
            `JuncapInitInstance(AB_i, LS_i, LG_i, VMAX, exp_VMAX_over_phitd, vbimin, vch, vfmin, vbbtlim)

            // Initialization of (global) variables; required for some verilog-A compilers
            ISATFOR1   = 0.0;
            MFOR1      = 1.0;
            MFOR2      = 1.0;
            ISATFOR2   = 0.0;
            MREV       = 1.0;
            ISATREV    = 0.0;
            m0flag     = 0.0;
            xhighf1    = 0.0;
            expxhf1    = 0.0;
            xhighf2    = 0.0;
            expxhf2    = 0.0;
            xhighr     = 0.0;
            expxhr     = 0.0;

            m0_rev     = 0.0;
            mcor_rev   = 0.0;
            I1_cor     = 0.0;
            I2_cor     = 0.0;
            I3_cor     = 0.0;
            I4_cor     = 0.0;
            I5_cor     = 0.0;
            tt0        = 0.0;
            tt1        = 0.0;
            tt2        = 0.0;
            qpreftot   = 0.0;
            qflagbot   = 1.0;
            qflagsti   = 1.0;
            qflaggat   = 1.0;
            alphaje    = 0.0;
            tmpv       = 0.0;
            vjv        = 0.0;

            if (SWJUNEXP_i == 1.0) begin : JUNCAPexpressInit
                // The variables in the macro below are (re-)declared LOCALY, to keep
                // them separated from their globally declared counterparts. This trick
                // allows one to use the "juncapcommon" macro both in the JUNCAP-express
                // initialization and in the full-JUNCAP evalutation, while in the former
                // the verilog-A compiler will still consider the variables as
                // voltage-INdependent. This is essential to avoid recomputation of the
                // JUNCAP-express initialization at each bias-step.
                `LocalGlobalVars
                // results computed here are not used elsewhere
                real ijunbot, ijunsti, ijungat, qjunbot, qjunsti, qjungat;

                // Initialization of (local) variables; required for some verilog-A compilers
                ysq = 0.0;
                terfc = 0.0;
                erfcpos = 0.0;
                h1 = 0.0;
                h2 = 0.0;
                h2d = 0.0;
                h3 = 0.0;
                h4 = 0.0;
                h5 = 0.0;
                idmult = 0.0;
                vj = 0.0;
                z = 0.0;
                zinv = 0.0;
                two_psistar = 0.0;
                vjlim = 0.0;
                vjsrh = 0.0;
                vbbt = 0.0;
                vav = 0.0;
                tmp = 0.0;
                id = 0.0;
                isrh = 0.0;
                vbi_minus_vjsrh = 0.0;
                wsrhstep = 0.0;
                dwsrh = 0.0;
                wsrh = 0.0;
                wdep = 0.0;
                asrh = 0.0;
                itat = 0.0;
                btat = 0.0;
                twoatatoverthreebtat = 0.0;
                umaxbeforelimiting = 0.0;
                umax = 0.0;
                sqrtumax = 0.0;
                umaxpoweronepointfive = 0.0;
                wgamma = 0.0;
                wtat = 0.0;
                ktat = 0.0;
                ltat = 0.0;
                mtat = 0.0;
                xerfc = 0.0;
                erfctimesexpmtat = 0.0;
                gammamax = 0.0;
                ibbt = 0.0;
                Fmaxr = 0.0;
                fbreakdown = 0.0;
                qjunbot = 0.0;
                qjunsti = 0.0;
                qjungat = 0.0;

                // Computation of JUNCAP-express internal parameters
                `JuncapExpressInit1(AB_i, LS_i, LG_i, VMAX, exp_VMAX_over_phitd, vbimin, vch, vfmin, vbbtlim)
                `JuncapExpressInit2(AB_i, LS_i, LG_i, VMAX, exp_VMAX_over_phitd, vbimin, vch, vfmin, vbbtlim)
                `JuncapExpressInit3(AB_i, LS_i, LG_i, ISATFOR1, MFOR1, ISATFOR2, MFOR2, ISATREV, MREV, m0flag)
                `JuncapExpressInit4(AB_i, LS_i, LG_i, qflagbot, qflagsti, qflaggat)
                `JuncapExpressInit5(AB_i, LS_i, LG_i, ISATFOR1, ISATFOR2, ISATREV, xhighf1, expxhf1, xhighf2, expxhf2, xhighr, expxhr)

            end // JUNCAPexpressInit

        end // initializeInstance

        /////////////////////////////////////////////////////////////////////////////
        //
        //  DC-bias dependent quantities (calculations for current contribs)
        //
        /////////////////////////////////////////////////////////////////////////////

        begin : evaluateStaticDynamic
            VAK = TYPE * V(A, K);
            if (SWJUNEXP_i == 1.0) begin
                `JuncapExpressCurrent(VAK, MFOR1, ISATFOR1, MFOR2, ISATFOR2, MREV, ISATREV, m0flag, xhighf1, expxhf1, xhighf2, expxhf2, xhighr, expxhr, ijun)
                begin : evaluateDynamic
                    `JuncapExpressCharge(VAK, AB_i, LS_i, LG_i, vfmin, vch, qflagbot, qflagsti, qflaggat, qjunbot, qjunsti, qjungat)
                end
            end else begin
                `juncapcommon(VAK, AB_i, LS_i, LG_i, VMAX, exp_VMAX_over_phitd, vbimin, vch, vfmin, vbbtlim, ijunbot, qjunbot, ijunsti, qjunsti, ijungat, qjungat)
                ijun = AB_i * ijunbot + LS_i * ijunsti + LG_i * ijungat;
            end
            qjun = AB_i * qjunbot + LS_i * qjunsti + LG_i * qjungat;

        end // evaluateStaticDynamic

        /////////////////////////////////////////////////////////////////////////////
        //
        //  Current contribs
        //
        /////////////////////////////////////////////////////////////////////////////

        begin : loadStatic
            I(A, K) <+ (TYPE * MULT_i) * ijun;
        end // loadStatic

        /////////////////////////////////////////////////////////////////////////////
        //
        //  ddt() contribs from charges
        //
        /////////////////////////////////////////////////////////////////////////////

        begin : loadDynamic
            I(A, K) <+ ddt((TYPE * MULT_i) * qjun);
        end // loadDynamic

        /////////////////////////////////////////////////////////////////////////////
        //
        //  Noise
        //
        /////////////////////////////////////////////////////////////////////////////

        begin : noise
            jnoise = (2 * `QELE * MULT_i) * abs(ijun);
            I(A, K) <+ white_noise(jnoise, "shot");
        end // noise

`ifdef insideADMS // OPinfo
        /////////////////////////////////////////////////////////////////////////////
        //
        // Operating point info
        //
        /////////////////////////////////////////////////////////////////////////////

        begin : OPinfo

            // The output variables defined below are currently not available in
            // Verilog-A, but only in the SiMKit-C-code which was generated from
            // this source. Similar functionality will be available in Verilog-A
            // from Verilog-A version 2.2 onwards. However, a different syntax is
            // to be used (see Verilog AMS language reference manual, version 2.2,
            // november 2004, Accellera).

            vak     = VAK;
            cjbot   = TYPE * MULT_i * AB_i * ddx(qjunbot, V(A, K));
            cjgat   = TYPE * MULT_i * LG_i * ddx(qjungat, V(A, K));
            cjsti   = TYPE * MULT_i * LS_i * ddx(qjunsti, V(A, K));
            cj      = cjbot + cjgat + cjsti;
            if (SWJUNEXP_i == 1.0) begin
                ijbot   = 0.0;
                ijgat   = 0.0;
                ijsti   = 0.0;
            end else begin
                ijbot   = MULT_i * AB_i * ijunbot;
                ijgat   = MULT_i * LG_i * ijungat;
                ijsti   = MULT_i * LS_i * ijunsti;
            end
            ij      = MULT_i * ijun;
            si      = jnoise;
        end // OPinfo
`endif // insideADMS OPinfo

   end // analogBlock

endmodule
