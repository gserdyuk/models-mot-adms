//======================================================================================
//======================================================================================
// Filename: psp102e.va
//======================================================================================
//======================================================================================
//
//  (c) Copyright 2007, All Rights Reserved, NXP Semiconductors
//
//
//  Version: 102.2, October 2007
//
//======================================================================================
//======================================================================================
//
// Further information can be found in the file readme.txt
//

`include "discipline.h"

`include "SIMKIT_macrodefs.include"

`include "JUNCAP200_macrodefs.include"

`include "PSP102_macrodefs.include"

/////////////////////////////////////////////////////////////////////////////
//
//  PSP local model code
//
/////////////////////////////////////////////////////////////////////////////

`define LocalModel

module PSP102EVA(D, G, S, B)

`P(
  info = "PSP local MOSFET Model"
  version = `VERS
  revision = `VREV
  simkit:name = "psp102e"
  simkit:desc = "psp_102e"
);

`include "PSP102_module.include"

endmodule
